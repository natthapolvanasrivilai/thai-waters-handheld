USB indicator unplugged / R0003 / engineering envelopes in volts and ohms
Vusb vbus 0 0
Rlimit vbus lamp 2700
Rleak lamp 0 1T
Gled lamp 0 VALUE = {MAX(0,V(lamp)-2.7)/10}
.DC Vusb 0.00000 0.00010 0.0001
.PRINT DC V(vbus) V(lamp) I(Vusb)
.END
