Thai Waters Rev F | usb_low_host_lossy
* 4.75 V host, 0.65 ohm loop; 330 to 650 mA.
* Model: Cable, connector, bead resistance and VBUS input capacitance; ideal imposed USB load.
Vhost src 0 4.75
Rloop src vbus 0.65
Cin vbus 0 10u
Iload vbus 0 PULSE(0.33 0.65 1m 5u 5u 2m 9m)
.TRAN 10u 4m 0 5u
.PRINT TRAN V(vbus) I(Vhost)
.END
