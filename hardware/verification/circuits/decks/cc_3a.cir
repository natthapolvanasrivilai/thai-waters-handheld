Thai Waters Rev F | cc_3a
* 5 V resistor-source fixture, Rp 10000 ohm, Rd 5100 ohm.
* Model: One active CC pin. Repeat both plug orientations. Open resistance is a deliberate assembly fault.
Vr src 0 5
Rhost src cc 10000
Rdevice cc 0 5100
.TRAN 1u 5u
.PRINT TRAN V(cc)
.END
