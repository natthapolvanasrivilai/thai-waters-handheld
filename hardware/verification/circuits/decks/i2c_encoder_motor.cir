Thai Waters Rev F | i2c_encoder_motor
* Effective pull-up 5000 ohm and 100 pF at J8.
* Model: Lumped released edge; board population, MOS level shifters and actual capacitance must be measured.
Vrelease drv 0 DC 0 PULSE(0 3.3 1u 1n 1n 30u 60u)
Rpull drv bus 5000.000000
Cbus bus 0 100p
Vdd rail 0 3.3
Rparallel rail sink 5000.000000
Vclamp sink 0 0.4
.TRAN 5n 8u 0 5n
.PRINT TRAN V(bus) I(Vclamp)
.END
