Thai Waters Rev F | light_low_vf_high_rail
* 3.40 V rail, 2.80 V LED drop with 6.46 ohm series R3.
* Model: Full-duty steady slice of R3 + aggregate panel LED drop and AO3400 on resistance. Actual Vf, current limit and thermal rating require the panel drawing.
Vdd v 0 3.4
R3 v led 6.46
Vled led sw 2.8
Ron sw 0 .08
.TRAN 1u 10u
.PRINT TRAN I(Vdd)
.END
