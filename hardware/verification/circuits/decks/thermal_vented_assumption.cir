Thai Waters Rev F | thermal_vented_assumption
* 0.22 W heat source, 55 K/W path and 25 C ambient.
* Model: Electrothermal analogy 1 V = 1 C, 1 A = 1 W. Aggregate heat and thermal resistance are assumed; result is a hot-node sensitivity only.
Vamb amb 0 25
Rth hot amb 55
Cth hot 0 8
Iheat 0 hot PULSE(0 0.22 1 1 1 18000 36000)
.TRAN 12 7200 0 10
.PRINT TRAN V(hot)
.END
