Thai Waters Rev F | rail_typ_assumed
* 28 uF effective, ESR 0.035 ohm, 5 us latency, 5 us response.
* Model: Incremental charge-deficit bound prior to loop recovery around 3.30 V. Wi-Fi current step is assumed.
Vref v 0 3.3
Rslow v rail 200
Resr rail cap 0.035
Ceff cap 0 28u
Iload rail 0 PWL(0 0 50u 0 50.1u 0.3 250u 0.3)
Iloop 0 rail PWL(0 0 55u 0 60u 0.3 250u 0.3)
.TRAN .2u 200u 0 .2u
.PRINT TRAN V(rail)
.END
