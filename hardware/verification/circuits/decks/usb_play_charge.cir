Thai Waters Rev F | usb_play_charge
* 5.00 V host, 0.25 ohm loop; 330 to 500 mA.
* Model: Cable, connector, bead resistance and VBUS input capacitance; ideal imposed USB load.
Vhost src 0 5
Rloop src vbus 0.25
Cin vbus 0 10u
Iload vbus 0 PULSE(0.33 0.5 1m 5u 5u 2m 9m)
.TRAN 10u 4m 0 5u
.PRINT TRAN V(vbus) I(Vhost)
.END
